property buffer_writes {
    component = reg;
    type = boolean;
};

addrmap cloud_ceiling_regmap {
    name = "Cloud Ceiling Regs";

    default accesswidth = 16;
    default regwidth = 16;
    default sw = rw;
    default hw = r;
    littleendian;

    regfile {
        reg {
            name = "ID Register";

            field {
                desc = "ID value";
                sw = r;
                hw = na;
            } ID[15:0] = 0xC10D;
        } ID_REG @ 0x0;

        reg {
            name = "Scratch";

            field {
                desc = "Scratch field";
                hw = na;
            } DATA[15:0] = 0;
        } SCRATCH_REG @ 0x2;

        reg {
            name = "Reset Status";

            field {
                desc = "100 MHz Reset";
                sw = r;
                hw = w;
            } RESET_100[0:0] = 0;

            field {
                desc = "20 MHz Reset";
                sw = r;
                hw = w;
            } RESET_20[1:1] = 0;
        } RESET_STATUS_REG @ 0x4;

        reg {
            name = "FIFO Status";

            field {
                desc = "FIFO Underflow";
                onwrite = woclr;
                hwset;
            } UNDERFLOW[0:0] = 0;

            field {
                desc = "FIFO Overflow";
                onwrite = woclr;
                hwset;
            } OVERFLOW[4:4] = 0;
        } FIFO_STATUS_REG @ 0x10;

        reg {
            name = "FIFO Empty Count";

            field {
                desc = "Empty Count";
                sw = r;
                hw = w;
            } COUNT[15:0] = 0;
        } FIFO_EMPTY_REG @ 0x12;

        reg {
            name = "White Color";

            field {
                desc = "White Value";
                swmod;
            } VALUE[15:0] = 0x0818;
        } WHITE_COLOR_L_REG @ 0x14;

        reg {
            name = "White Color";

            field {
                desc = "White Value";
                swmod;
            } VALUE[7:0] = 0x40;
        } WHITE_COLOR_H_REG @ 0x16;
        // Register arrays appear to break synlog
    } REGS @ 0x0;

    /*
     * Burst support on memories.
     *
     * The default UVM implementation of uvm_reg_map splits all transactions into
     * multiples of the bus width. It has to do this because it translates accesses
     * through uvm_reg_bus_op, which uses uvm_reg_data_t, which has no concept of
     * burst transfers. To avoid this, we would either need to provide extension
     * data to the accesses or implement a different frontdoor implementation.
     *
     * Rather than doing either of the above, we treat the bus as being wider than
     * it really is, up to the maximum UVM_REG_DATA_WIDTH. This allows uvm_reg_bus_op
     * to represent bursts, and the driver receives wide uvm_tlm_gps, implementing
     * the actual burst.
     */
    mem {
        name = "Color FIFO Memory";
        sw = w;

        memwidth = 256;
        mementries = 128;
    } external FIFO_MEM @ 0x1000;
};
